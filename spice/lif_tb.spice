* ============================================================
* SKY130 LIF - Minimal Membrane Dynamics
* ============================================================

.title SKY130 LIF - Minimal Membrane Dynamics

.lib /tmp/sky130_continuous_test/sky130_tt.lib.spice tt

* ------------------------------------------------------------
* Parameters
* ------------------------------------------------------------

.param VDD   = 1.8
.param VMEM0 = 0

.param CMEM  = 1p

.param LLEAK = 20
.param WLEAK = 7

.param VBIAS = 0.4

.param IIN   = 5n

* ------------------------------------------------------------
* Supply
* ------------------------------------------------------------

Vdd vdd 0 {VDD}

* ------------------------------------------------------------
* Membrane
* ------------------------------------------------------------

Cmem vmem 0 {CMEM}

.ic v(vmem)={VMEM0}

* ------------------------------------------------------------
* Input current
* ------------------------------------------------------------

Iin 0 vmem DC {IIN}

* ------------------------------------------------------------
* Leakage transistor
* ------------------------------------------------------------

Vbias bias 0 {VBIAS}

Xleak vmem bias 0 0 sky130_fd_pr__nfet_01v8 l={LLEAK} w={WLEAK}

* ------------------------------------------------------------
* Transient analysis
* ------------------------------------------------------------

.control

tran 1n 100u

set filetype=ascii

print v(vmem)

write lif_tb.raw v(vmem) v(bias)

.endc

.end
